* 03_GECIKME_TARAMA - visible schematic and CIRCUIT_CORE have identical connectivity
.include MODELS.inc
.include NOISE_RECORDS.inc
.include TEST_03_GECIKME_TARAMA.inc
.include CIRCUIT_CORE.inc
.end
